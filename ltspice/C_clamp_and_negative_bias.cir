GaN half-bridge double-pulse -- C_clamp_and_negative_bias.cir
* -------------------------------------------------------------------
* CLAMP + -2 V OFF-BIAS - the shipped configuration.
*
* HOW TO RUN IN LTSPICE
*   1. Keep this file with egan.lib and segdrv.lib in the same folder.
*   2. LTspice > File > Open, set the file-type filter to 'All Files'.
*   3. Open this file and press Run.
*   4. Probe V(hsg,sw) -- the high-side gate-source voltage. That is
*      the trace this project is about. Threshold is 1.4 V.
*   5. View > SPICE Error Log shows the measured vspur.
*
* The active Miller clamp is REAL and present here, in segdrv.lib:
*   Sclk out nclk clk ref SWP      (the clamp switch)
*   Rclk nclk vn {rclamp}          (0.5 ohm to the negative rail)
* CLKEN=1 selects the clamp; VNEG=-2 selects the off-bias rail.
*
* VERIFIED in ngspice on this exact file, 1 Sep 2026:
*   vspur = -1.176 V -> SAFE, margin +2.576 V
* -------------------------------------------------------------------
* ===================================================================
* dpt.cir -- half-bridge double-pulse testbench
*
* Sequence (all timing is what the FPGA would emit):
*   0    .. T1   LS on, HS off        -- settle, inductor at ILOAD
*   T1        LS turns OFF            -- E_off, V_DS overshoot, ringing
*   T1..T2    DEAD TIME               -- HS conducts in 3rd quadrant, E_dt
*   T2        HS turns ON
*   T3        HS turns OFF
*   T3..T4    DEAD TIME
*   T4        LS turns ON  (hard)     -- E_on, and CROSSTALK on the HS gate
*
* The crosstalk event of interest is at T4: SW slews up... no, DOWN to 0,
* so the HS device sees dV_DS/dt > 0 across its Miller capacitance and
* its gate is pushed toward Vth.  Margin = Vth - max(V_GS,HS).
* ===================================================================

.include egan.lib
.include segdrv.lib

* ==================== PARAM BLOCK (swept by run_sweep.py) ==========
.param VBUS=100
.param ILOAD=10
.param VDRV=5
.param VNEG=-2
.param NPU_LS=8
.param NPD_LS=8
.param NPU_HS=8
.param NPD_HS=8
.param DT=15n
.param CLKEN=1
.param CLKDEL=4n
.param RUNIT=8
.param TJ=25
* ==================== END PARAM BLOCK ==============================

* temperature scaling of the GaN device (datasheet trend:
*   Rds(on) roughly doubles 25->125 C, Vth falls slightly)
.param KT   = {1 + 0.009*(TJ-25)}
.param BH_T = {5.55/KT}
.param VTH_T= {1.4 - 0.0015*(TJ-25)}

.param VOUT  = {VBUS/2}
.param LLOOP = 3n
.param LLOAD = 100u
.param TR    = 0.1n
.param T1 = 1u
.param T2 = {T1+DT}
.param T3 = 2u
.param T4 = {T3+DT}
.param TSTOP = 3u

* ---------------- power stage --------------------------------------
Vbus   bus 0 DC {VBUS}
Rloop  bus n1  0.3                    ; loop R including skin effect at ~300 MHz.
*                                      10m would give Q~600, which is unphysical:
*                                      real GaN half-bridges ring ~6 cycles, not 30.
Lloop  n1  hstop {LLOOP}
Vshs   hstop hsd DC 0                 ; HS drain current sense
Xhs    hsd hsg sw EGAN params: vth={VTH_T} bh={BH_T}
Vsls   sw  lsd DC 0                   ; LS drain current sense
Xls    lsd lsg 0  EGAN params: vth={VTH_T} bh={BH_T}

Lload  out sw {LLOAD} IC={ILOAD}
Vout   out 0 DC {VOUT}

* ---------------- FPGA timing (gnd-referenced logic) ---------------
Vpwmls pwmls 0 PWL(0 1 {T1} 1 {T1+TR} 0 {T4} 0 {T4+TR} 1)
Vpwmhs pwmhs 0 PWL(0 0 {T2} 0 {T2+TR} 1 {T3} 1 {T3+TR} 0)
Vclkls lsclk 0 PWL(0 0 {T1+CLKDEL} 0 {T1+CLKDEL+TR} {CLKEN} {T4} {CLKEN} {T4+TR} 0)
Vclkhs clkhs 0 PWL(0 {CLKEN} {T2} {CLKEN} {T2+TR} 0 {T3+CLKDEL} 0 {T3+CLKDEL+TR} {CLKEN})

* ---------------- low-side driver (gnd referenced) -----------------
Vlsvp  lsvp 0 DC {VDRV}
Vlsvn  lsvn 0 DC {VNEG}
Blspu  lspu 0 V = {v(pwmls)}
Blspd  lspd 0 V = {1-v(pwmls)}
Xdrvls lspu lspd lsclk lsg lsvp lsvn 0 SEGDRV
+      params: npu={NPU_LS} npd={NPD_LS} runit={RUNIT} rclamp=0.5

* ---------------- high-side driver (floating on SW) ----------------
* ideal level shifters -- a real design needs a proper HV shifter,
* which is listed as future work, not simulated here.
Vhsvp  hsvp sw DC {VDRV}
Vhsvn  hsvn sw DC {VNEG}
Bhspu  hspu sw V = {v(pwmhs)}
Bhspd  hspd sw V = {1-v(pwmhs)}
Bhsclk hsclkl sw V = {v(clkhs)}
Xdrvhs hspu hspd hsclkl hsg hsvp hsvn sw SEGDRV
+      params: npu={NPU_HS} npd={NPD_HS} runit={RUNIT} rclamp=0.5

* ---------------- analysis -----------------------------------------
* NOTE: trapezoidal on purpose.  Gear damps numerically and would
* quietly flatter the ringing metric, which is one of the objectives.
.options reltol=1e-3 abstol=1e-10 vntol=1e-6 chgtol=1e-15 gmin=1e-12
.ic v(sw)=0 v(lsg)={VDRV} v(hsg)={VNEG} v(out)={VOUT}

.tran 0.02n {TSTOP} 0 0.05n uic

.save v(sw) v(lsg) v(hsg) v(lsd) v(hsd)
+ i(vsls) i(vshs)
.meas TRAN vspur MAX V(hsg,sw) FROM 2.015u TO 2.10u
.end
