// Clamped inductive double-pulse test — GaN half-bridge
// M0 feasibility gate. Run:  spectre dpt_gan.scs -format psfascii -raw ./psf
//
// BEFORE RUNNING: point the include below at a GaN model Spectre can parse.
// Vendor models are usually LTspice/PSpice flavoured and may need hand-editing,
// or replace with a Verilog-A ASM-HEMT. This line is the M0 gate.

simulator lang=spectre
global 0

include "models/gan_hemt.scs"          // <-- SUPPLY THIS. See MILESTONES.md M0.1

// ---------------------------------------------------------------- parameters
parameters VDC=400          // DC-link voltage            [V]
parameters ITARGET=10       // current at first turn-off  [A]
parameters LLOAD=200u       // load inductor              [H]
parameters LLOOP=5n         // commutation loop inductance per rail [H]
parameters LCSI=0.5n        // common-source inductance   [H]
parameters CDC=10u          // DC-link capacitance        [F]
parameters RG_ON=2          // gate resistance, turn-on   [ohm]
parameters RG_OFF=1         // gate resistance, turn-off  [ohm]
parameters VGS_ON=6         // GaN gate drive is 6 V, not 12 V
parameters VGS_OFF=0        // set negative (-3) to study crosstalk margin

// first pulse charges LLOAD to ITARGET:  t = L*I/V
parameters TP1=(LLOAD*ITARGET)/VDC
parameters TOFF=2u          // off interval — the measurement window
parameters TP2=1u           // second pulse — turn-on at current

// ---------------------------------------------------------------- power stage
Vdc   (dcp 0)        vsource dc=VDC type=dc
Cdc   (dcp 0)        capacitor c=CDC
Lp    (dcp mid_p)    inductor  l=LLOOP      // upper rail loop inductance
Ln    (mid_n 0)      inductor  l=LLOOP      // lower rail loop inductance

// High-side device — held off; freewheels through reverse conduction
XQH   (mid_p sw gh_s) gan_hemt
Lcsh  (gh_s sw)      inductor  l=LCSI

// Low-side device — the DUT
XQL   (sw gl_d gl_s) gan_hemt
Lcsl  (gl_s mid_n)   inductor  l=LCSI

// Load inductor from switch node to the upper rail (clamped inductive load)
Lload (dcp sw)       inductor  l=LLOAD

// ---------------------------------------------------------------- gate drives
// Low-side DUT: two pulses. High-side: held off for the whole run.
Vgl   (gl_g 0) vsource type=pwl wave=[ \
        0            VGS_OFF \
        1n           VGS_OFF \
        1.001n       VGS_ON  \
        TP1          VGS_ON  \
        TP1+1n       VGS_OFF \
        TP1+TOFF     VGS_OFF \
        TP1+TOFF+1n  VGS_ON  \
        TP1+TOFF+TP2 VGS_ON  \
        TP1+TOFF+TP2+1n VGS_OFF ]
Rgl   (gl_g gl_d_g)  resistor r=RG_ON

Vgh   (gh_g 0) vsource dc=VGS_OFF type=dc
Rgh   (gh_g gh_s)    resistor r=RG_OFF

// ---------------------------------------------------------------- analyses
tran tran stop=TP1+TOFF+TP2+2u errpreset=conservative maxstep=100p write="spectre.ic"

// M0 pass/fail is read off these:
//   V(sw)      -> turn-off overshoot and ring-down
//   I(Lload)   -> should reach ITARGET at t=TP1
//   V(gh_s,..) -> high-side gate excursion = crosstalk
save sw dcp mid_p mid_n gl_g gh_g
save Lload:1 Lp:1

simulator lang=spice
.end
